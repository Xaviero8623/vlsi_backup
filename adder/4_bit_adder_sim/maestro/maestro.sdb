ADE simulation setup
Run mode: Single Run, Sweeps and Corners
Tests:
  adder_4_bit_adder_sim_1: adder/4_bit_adder_sim/schematic, simulator hspiceD

ADE simulation setup
Test adder_4_bit_adder_sim_1: adder/4_bit_adder_sim/schematic, simulator hspiceD
  Models: /opt/PDK/FreePDK45/ncsu_basekit/models/hspice/hspice_nom.include
  Analysis tran: stop=40n step=0.5n
  Signals: /a0, /a1, /a2, /a3, /b0, /b1, /b2, /b3, /s0, /s1, /s2, /s3, /cout
Run mode: Single Run, Sweeps and Corners

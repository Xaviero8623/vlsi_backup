ADE simulation setup
Test adder_full_adder_sim_1: adder/full_adder_sim/schematic, simulator hspiceD
  Models: /opt/PDK/FreePDK45/ncsu_basekit/models/hspice/hspice_nom.include
  Analysis tran: stop=20n step=0.5n
  Signals: /ina, /inb, /cin, /sum, /cout
Run mode: Single Run, Sweeps and Corners

ADE simulation setup
Run mode: Single Run, Sweeps and Corners
Tests:
  adder_full_adder_sim_1: adder/full_adder_sim/schematic, simulator hspiceD

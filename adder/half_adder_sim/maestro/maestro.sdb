ADE simulation setup
Run mode: Single Run, Sweeps and Corners
Tests:
  adder_half_adder_sim_1: adder/half_adder_sim/schematic, simulator hspiceD

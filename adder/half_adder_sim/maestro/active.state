ADE simulation setup
Test adder_half_adder_sim_1: adder/half_adder_sim/schematic, simulator hspiceD
  Models: /opt/PDK/FreePDK45/ncsu_basekit/models/hspice/hspice_nom.include
  Analysis tran: stop=10n step=0.5n
  Signals: /ina, /inb, /sum, /carry
Run mode: Single Run, Sweeps and Corners

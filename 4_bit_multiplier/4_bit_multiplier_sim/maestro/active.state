ADE simulation setup
Test 4_bit_multiplier_4_bit_multiplier_sim_1: 4_bit_multiplier/4_bit_multiplier_sim/schematic, simulator hspiceD
  Models: /opt/PDK/FreePDK45/ncsu_basekit/models/hspice/hspice_nom.include
  Analysis tran: stop=40n step=0.5n
  Signals: /b3, /b2, /b1, /b0, /a3, /a2, /a1, /a0, /s7, /s6, /s5, /s4, /s3, /s2, /s1, /s0
Run mode: Single Run, Sweeps and Corners

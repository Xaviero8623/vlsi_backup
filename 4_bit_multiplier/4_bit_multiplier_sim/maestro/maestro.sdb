ADE simulation setup
Run mode: Single Run, Sweeps and Corners
Tests:
  4_bit_multiplier_4_bit_multiplier_sim_1: 4_bit_multiplier/4_bit_multiplier_sim/schematic, simulator hspiceD

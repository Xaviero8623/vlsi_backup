ADE simulation setup
Test Basic_parts_and_sim_1: Basic_parts/and_sim/schematic, simulator hspiceD
  Models: /opt/PDK/FreePDK45/ncsu_basekit/models/hspice/hspice_nom.include
  Analysis tran: stop=50n step=0.5n
  Signals: /ina, /inb, /out
Run mode: Single Run, Sweeps and Corners

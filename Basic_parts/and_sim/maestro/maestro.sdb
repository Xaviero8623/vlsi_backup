ADE simulation setup
Run mode: Single Run, Sweeps and Corners
Tests:
  Basic_parts_and_sim_1: Basic_parts/and_sim/schematic, simulator hspiceD

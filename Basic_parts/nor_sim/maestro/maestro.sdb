ADE simulation setup
Run mode: Single Run, Sweeps and Corners
Tests:
  Basic_parts_nor_sim_1: Basic_parts/nor_sim/schematic, simulator hspiceD

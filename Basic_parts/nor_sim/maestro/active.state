ADE simulation setup
Test Basic_parts_nor_sim_1: Basic_parts/nor_sim/schematic, simulator hspiceD
  Models: /opt/PDK/FreePDK45/ncsu_basekit/models/hspice/hspice_nom.include
  Analysis tran: stop=40n step=10p
  Signals: /ina, /inb, /out
Run mode: Single Run, Sweeps and Corners

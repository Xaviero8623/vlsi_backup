ADE simulation setup
Test Basic_parts_T_gate_sim_1: Basic_parts/T_gate_sim/schematic, simulator hspiceD
  Models: /opt/PDK/FreePDK45/ncsu_basekit/models/hspice/hspice_nom.include
  Analysis tran: stop=40n step=0.5n
  Signals: /in, /Vc, /out, /nVC
Run mode: Single Run, Sweeps and Corners

ADE simulation setup
Run mode: Single Run, Sweeps and Corners
Tests:
  Basic_parts_T_gate_sim_1: Basic_parts/T_gate_sim/schematic, simulator hspiceD

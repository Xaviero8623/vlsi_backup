ADE simulation setup
Run mode: Single Run, Sweeps and Corners
Tests:
  Basic_parts_clocked_inv_sim_1: Basic_parts/clocked_inv_sim/schematic, simulator hspiceD

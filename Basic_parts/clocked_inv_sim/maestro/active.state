ADE simulation setup
Test Basic_parts_clocked_inv_sim_1: Basic_parts/clocked_inv_sim/schematic, simulator hspiceD
  Models: /opt/PDK/FreePDK45/ncsu_basekit/models/hspice/hspice_nom.include
  Analysis tran: stop=40n step=0.5n
  Signals: /!c, /in, /c, /out, /V3/MINUS (terminal), /V3/PLUS (terminal)
Run mode: Single Run, Sweeps and Corners

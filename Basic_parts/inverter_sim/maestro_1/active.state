ADE simulation setup
Test Basic_parts_inverter_sim_1: Basic_parts/inverter_sim/schematic, simulator hspiceD
  Models: /opt/PDK/FreePDK45/ncsu_basekit/models/hspice/hspice_nom.include
  Analysis dc: sweep source start=0 stop=1
  Signals: /in, /out
Run mode: Single Run, Sweeps and Corners

ADE simulation setup
Run mode: Single Run, Sweeps and Corners
Tests:
  Basic_parts_inverter_sim_1: Basic_parts/inverter_sim/schematic, simulator hspiceD

ADE simulation setup
Run mode: Single Run, Sweeps and Corners
Tests:
  Basic_parts_xor_sim_1: Basic_parts/xor_sim/schematic, simulator hspiceD

ADE simulation setup
Test Basic_parts_xor_sim_1: Basic_parts/xor_sim/schematic, simulator hspiceD
  Models: /opt/PDK/FreePDK45/ncsu_basekit/models/hspice/hspice_nom.include
  Analysis tran: stop=40n step=0.5n
  Signals: /a, /b, /out
Run mode: Single Run, Sweeps and Corners

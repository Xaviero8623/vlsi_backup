ADE simulation setup
Test Basic_parts_nand_sim_1: Basic_parts/nand_sim/schematic, simulator hspiceD
  Models: /opt/PDK/FreePDK45/ncsu_basekit/models/hspice/hspice_nom.include
  Analysis tran: start=0n stop=40n step=1n
  Signals: /ina, /inb, /out
Run mode: Single Run, Sweeps and Corners

ADE simulation setup
Run mode: Single Run, Sweeps and Corners
Tests:
  Basic_parts_nand_sim_1: Basic_parts/nand_sim/schematic, simulator hspiceD

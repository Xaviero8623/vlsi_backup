ADE simulation setup
Run mode: Single Run, Sweeps and Corners
Tests:
  Basic_parts_2-1_mux_sim_1: Basic_parts/2-1_mux_sim/schematic, simulator hspiceD

ADE simulation setup
Run mode: Single Run, Sweeps and Corners
Tests:
  Counter_ff_sim_1: Counter/ff_sim/schematic, simulator hspiceD

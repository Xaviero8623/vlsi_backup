ADE simulation setup
Test Counter_ff_sim_1: Counter/ff_sim/schematic, simulator hspiceD
  Models: /opt/PDK/FreePDK45/ncsu_basekit/models/hspice/hspice_nom.include
  Analysis tran: stop=40n step=0.5n
  Signals: /d, /c, /out
Run mode: Single Run, Sweeps and Corners

ADE simulation setup
Test Counter_4_bit_counter_sim_1: Counter/4_bit_counter_sim/schematic, simulator hspiceD
  Models: /opt/PDK/FreePDK45/ncsu_basekit/models/hspice/hspice_nom.include
  Analysis tran: stop=160n step=1n
  Signals: /c_ext, /en, /load, /out, /q0, /q1, /q2, /q3
Run mode: Single Run, Sweeps and Corners

ADE simulation setup
Run mode: Single Run, Sweeps and Corners
Tests:
  Counter_8_bit_counter_sim_1: Counter/8_bit_counter_sim/schematic, simulator hspiceD
